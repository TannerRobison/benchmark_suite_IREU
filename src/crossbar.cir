*==========================================================
* 2x2 HP Memristor Crossbar
*==========================================================

.include "hp_memristor.cir"

******************************************************
* Input Voltages (Rows)
******************************************************

.param VIN0=0.25
.param VIN1=0.75

VROW0 row0 0 DC {VIN0}
VROW1 row1 0 DC {VIN1}

******************************************************
* Memristor Array
******************************************************

X00 row0 col0 memristor PARAMS: Rinit=1k
X01 row0 col1 memristor PARAMS: Rinit=100k
X02 row0 col2 memristor PARAMS: Rinit=50k
X03 row0 col3 memristor PARAMS: Rinit=70k

X10 row1 col0 memristor PARAMS: Rinit=1k
X11 row1 col1 memristor PARAMS: Rinit=100k
X12 row1 col2 memristor PARAMS: Rinit=50k
X13 row1 col3 memristor PARAMS: Rinit=70k

******************************************************
* Column Loads
******************************************************

RLOAD0 col0 0 1k
RLOAD1 col1 0 1k
RLOAD2 col2 0 1k
RLOAD3 col3 0 1k

******************************************************
* Simulation
******************************************************

.tran 1n 100n uic

.control

run

print v(col0)
print v(col1)
print v(col2)
print v(col3)
save all
.endc

.end
